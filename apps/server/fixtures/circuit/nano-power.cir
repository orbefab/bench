nano-power
Vvusb src 0 DC 5.000000000000e+0
Rrcable src n1 2.0000000000000001e-1
Dd n1 rail Dd
Ccbulk rail 0 2.0000000000000002e-5
Iiboard rail 0 DC 5.000000000000e-2
Iistall rail 0 PWL(0 0.000000000000e+0 1.000000000000e-3 0.000000000000e+0 1.000000001000e-3 7.000000000000e-1)
.model Dd D(Is=1.1430149848918938e-4 N=1.8219234399737052e+0 Rs=2.1735968298739836e-2 EG=1.11 XTI=3)
.options reltol=1e-6 abstol=1e-12 vntol=1e-7 gmin=1e-12 method=gear temp=25 tnom=25
.tran 9.9999999999999995e-8 3.0000000000000001e-3 0 9.9999999999999995e-8
.end
