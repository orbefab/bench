rc-step
Vvs in 0 PWL(0 0.000000000000e+0 1e-12 1.000000000000e+0)
Rr in out 1.0000000000000000e+3
Cc out 0 9.9999999999999995e-7
.options reltol=1e-6 abstol=1e-12 vntol=1e-7 gmin=1e-12 method=gear temp=25 tnom=25
.tran 9.9999999999999995e-7 4.0000000000000001e-3 0 9.9999999999999995e-7
.end
