diode-clamp
Vvs in 0 SIN(0.000000000000e+0 5.000000000000e+0 1.000000000000e+3 0 0 0.000000000000e+0)
Rr in out 1.0000000000000000e+3
Dd out 0 Dd
.model Dd D(Is=2.5200000000000000e-9 N=1.7520000000000000e+0 Rs=5.6799999999999995e-1 EG=1.11 XTI=3)
.options reltol=1e-6 abstol=1e-12 vntol=1e-7 gmin=1e-12 method=gear temp=25 tnom=25
.tran 9.9999999999999995e-7 2.0000000000000000e-3 0 9.9999999999999995e-7
.end
