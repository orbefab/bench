divider
Vvs in 0 PWL(0 0.000000000000e+0 1e-12 5.000000000000e+0)
Rr1 in mid 1.0000000000000000e+3
Rr2 mid 0 1.0000000000000000e+3
.options reltol=1e-6 abstol=1e-12 vntol=1e-7 gmin=1e-12 method=gear temp=25 tnom=25
.tran 1.0000000000000001e-5 2.0000000000000001e-4 0 1.0000000000000001e-5
.end
