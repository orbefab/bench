nano-d13
Vvusb src 0 DC 5.000000000000e+0
Rrs src term 5.0000000000000000e-1
Ds4 term v5 Ds4
Rc106r v5 c106 5.0000000000000000e+0
Cc106 c106 0 1.0000000000000001e-5
Ccvcc v5 0 9.9999999999999995e-8
Ccavcc v5 0 9.9999999999999995e-8
Rrrst v5 nrst 1.0000000000000000e+3
Ccrst v5 nrst 9.9999999999999995e-8
Rrled d13 leda 1.0000000000000000e+3
Dled leda 0 Dled
Rd13leak d13 0 5.0000000000000000e+6
Sd13h v5 d13 ctl_d13h 0 Sd13h
Vctl_d13h ctl_d13h 0 PULSE(1.000000000000e+0 0.000000000000e+0 5.000000000000e-4 1e-12 1e-12 4.999999980000e-4 1.000000000000e-3)
Sd13l d13 0 ctl_d13l 0 Sd13l
Vctl_d13l ctl_d13l 0 PULSE(0.000000000000e+0 1.000000000000e+0 5.000000000000e-4 1e-12 1e-12 4.999999980000e-4 1.000000000000e-3)
Iiboard v5 0 DC 2.520000000000e-2
.model Ds4 D(Is=1.1430149848918938e-4 N=1.8219234399737052e+0 Rs=2.1735968298739836e-2 EG=1.11 XTI=3)
.model Dled D(Is=3.5191328433049383e-16 N=2.2204522451395414e+0 Rs=1.3371100596794690e+1 EG=1.11 XTI=3)
.model Sd13h SW(Vt=0.5 Ron=2.5066666666666663e+1 Roff=1.0000000000000000e+12)
.model Sd13l SW(Vt=0.5 Ron=2.3399999999999999e+1 Roff=1.0000000000000000e+12)
.options reltol=1e-6 abstol=1e-12 vntol=1e-7 gmin=1e-12 method=gear temp=25 tnom=25
.tran 2.0000000000000000e-8 3.0000000000000001e-3 0 2.0000000000000000e-8
.end
