pin-led
Vvs src 0 PWL(0 0.000000000000e+0 1e-12 5.000000000000e+0)
Rrp src pin 2.5066666666666663e+1
Rrled pin a 1.0000000000000000e+3
Dled a 0 Dled
.model Dled D(Is=3.5191328433049383e-16 N=2.2204522451395414e+0 Rs=1.3371100596794690e+1 EG=1.11 XTI=3)
.options reltol=1e-6 abstol=1e-12 vntol=1e-7 gmin=1e-12 method=gear temp=25 tnom=25
.tran 9.9999999999999995e-7 4.9999999999999996e-5 0 9.9999999999999995e-7
.end
