uno-usb
Vvusb src 0 DC 5.000000000000e+0
Rrs src term 5.0000000000000000e-1
Rf1 term sw 1.4999999999999999e-1
Rt1 sw v5 5.9999999999999998e-2
Dt1d v5 sw Dt1d
Rpc2r v5 pc2 5.6437923082232402e+0
Cpc2 pc2 0 4.6999999999999997e-5
Cc2 v5 0 9.9999999999999995e-8
Cc4 v5 0 9.9999999999999995e-8
Cc6 v5 0 9.9999999999999995e-8
Cc7 v5 0 9.9999999999999995e-8
Iiboard v5 0 DC 5.000000000000e-2
Iiload v5 0 PWL(0 0.000000000000e+0 1.000000000000e-3 0.000000000000e+0 1.000000001000e-3 7.140000000000e-1)
.model Dt1d D(Is=6.1773198357150518e-13 N=1.0000000000000000e+0 Rs=0.0000000000000000e+0 EG=1.11 XTI=3)
.options reltol=1e-6 abstol=1e-12 vntol=1e-7 gmin=1e-12 method=gear temp=25 tnom=25
.tran 2.0000000000000000e-8 3.0000000000000001e-3 0 2.0000000000000000e-8
.end
