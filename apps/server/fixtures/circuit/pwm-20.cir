pwm-20
Vvs src 0 PULSE(5.000000000000e+0 0.000000000000e+0 4.081632653061e-4 1e-12 1e-12 1.632653059224e-3 2.040816326531e-3)
Rrp src pin 2.5066666666666663e+1
Rrf pin out 1.0000000000000000e+4
Cc out 0 9.9999999999999995e-7
.options reltol=1e-6 abstol=1e-12 vntol=1e-7 gmin=1e-12 method=gear temp=25 tnom=25
.tran 1.0000000000000001e-5 8.0000000000000002e-2 0 1.0000000000000001e-5
.end
